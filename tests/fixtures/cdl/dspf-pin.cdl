.SUBCKT IO_PAD PAD CORE
*|P (PAD B 0.0 0.0)
.PORT CORE DIRECTION=OUTPUT USE=SIGNAL
.ENDS IO_PAD
